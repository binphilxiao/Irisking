[IBIS Ver]   3.2
[File Name]   sprm111.ibs
[File Rev]   0.1
[Date]   March 18, 2003
[Source]   IBIS Model Generated from PACED 4.51F
[Disclaimer]   Please be aware that in the absence of a written agreement
|   Texas Instruments(TI) assumes no liability for:
|   (1) The accuracy of the IBIS models provided to your company
|   (2) The proper functioning of these Models in your design
|   or for any resulting applications
|   (3) Infringement of patents, copyrights or intellectual
|   property rights resulting from your use of these
|   models.
|   TI provides IBIS Models as a service to our customers and
|   therefore reserves the right to limit distribution of the
|   Models.
[Copyright]   Property of Texas Instruments Incorporated.
|   Unauthorized reproduction and/or distribution is strictly.
|   prohibited.
|   This product is protected under copyright law and trade
|   secret law as an unpublished work.
|   Created 2003,(C) Copyright 1999-2003,
|   Texas Instruments Incorporated., All Rights Reserved.
|   These commodities are under the U.S. Government
|   distribution license control. As such,they are not to be
|   re-exported without the prior approval of the U.S.
|   Department of Commerce.
[Notes]
|****** ****   ***** *****   ******  Package Models  **************************
[Component]   DM642_GDK
[Manufacturer]  Texas Instruments
[Package]
|Variable  Typ   Min   Max
 R_pkg   0.12581866  0.0708   0.1927
 L_pkg   2.32E-09   1.26E-09  3.57E-09
 C_pkg   1.14E-12   6.40E-13  1.77E-12
[Pin]   signal_name  model_name   R_pin   L_pin   C_pin
C1   PCLK   BPCI66T   0.1647   2.94E-09  1.24E-12
B4   NMI   IT33THYPD   0.1574   2.92E-09  1.37E-12
A4   TINP0   IT33THYPD   0.1714   3.17E-09  1.50E-12
C5   TOUT0   BT3325CTPD   0.1355   2.49E-09  1.22E-12
B5   TOUT1   BT3325CTPU   0.1504   2.77E-09  1.35E-12
A5   TINP1   IT33THYPD   0.1652   3.05E-09  1.47E-12
D6   CLKOUT4   BT3315DTHYPU   0.1173   2.16E-09  1.06E-12
C6   CLKOUT6   BT3315DTHYPU   0.1352   2.50E-09  1.19E-12
C7   VP2CTL2   BT3325CTHYPD   0.1341   2.47E-09  1.19E-12
D7   VP2CTL1   BT3325CTHYPD   0.1127   2.08E-09  1.01E-12
A7   VP2CLK0   IT33THYPD   0.1549   2.87E-09  1.36E-12
D8   VP2D01   BT3325CTHYPD   0.102   1.88E-09  9.12E-13
C8   VP2D00   BT3325CTHYPD   0.1197   2.20E-09  1.07E-12
B8   VP2CTL0   BT3325CTHYPD   0.1345   2.46E-09  1.21E-12
D9   VP2D05   BT3325CTHYPD   0.0977   1.77E-09  9.19E-13
C9   VP2D04   BT3325CTHYPD   0.114   2.07E-09  1.05E-12
B9   VP2D03   BT3325CTHYPD   0.1288   2.34E-09  1.18E-12
A9   VP2D02   BT3325CTHYPD   0.1437   2.63E-09  1.29E-12
D10   VP2D09   BT3325CTHYPD   0.0946   1.70E-09  9.01E-13
C10   VP2D08   BT3325CTHYPD   0.1127   2.05E-09  1.04E-12
B10   VP2D07   BT3325CTHYPD   0.1278   2.33E-09  1.18E-12
A10   VP2D06   BT3325CTHYPD   0.143   2.62E-09  1.29E-12
D11   VP2D13   BT3325CTHYPD   0.098   1.78E-09  9.06E-13
E11   VP2D14   BT3325CTHYPD   0.083   1.51E-09  7.64E-13
C11   VP2D12   BT3325CTHYPD   0.1081   1.98E-09  9.64E-13
B11   VP2D11   BT3325CTHYPD   0.1238   2.26E-09  1.12E-12
A11   VP2D10   BT3325CTHYPD   0.1391   2.56E-09  1.23E-12
E12   VP2D18   BT3325CTHYPD   0.0799   1.46E-09  7.29E-13
D12   VP2D17   BT3325CTHYPD   0.0931   1.70E-09  8.36E-13
C12   VP2D16   BT3325CTHYPD   0.1079   1.97E-09  9.71E-13
B12   VP2D15   BT3325CTHYPD   0.1228   2.25E-09  1.09E-12
E13   VP2D19   BT3325CTHYPD   0.1051   1.93E-09  9.27E-13
A13   VP2CLK1   BT3325CTHYPD   0.1518   2.67E-09  1.25E-12
A15   EMU0   BT3315DTHYPU   0.1531   2.82E-09  1.33E-12
A16   TCK   IT33THYPU   0.1598   2.93E-09  1.43E-12
C14   EMU1   BT3315DTHYPU   0.1107   2.01E-09  1.02E-12
B15   EMU2   BT3315DTHYPU   0.1318   2.37E-09  1.17E-12
C15   EMU3   BT3315DTHYPU   0.1149   2.09E-09  1.06E-12
D14   TRSTZ   IT33THYPD   0.0895   1.61E-09  8.52E-13
B16   EMU5   BT3315DTHYPU   0.1348   2.46E-09  1.21E-12
A17   EMU7   BT3315DTHYPU   0.1482   2.72E-09  1.32E-12
C16   EMU6   BT3315DTHYPU   0.1043   1.89E-09  9.63E-13
D15   EMU4   BT3315DTHYPU   0.0836   1.51E-09  7.86E-13
E15   TMS   IT33THYPU   0.0754   1.35E-09  7.23E-13
B17   EMU9   BT3315DTHYPU   0.1316   2.41E-09  1.18E-12
A18   TDI   IT33THYPU   0.1516   2.78E-09  1.35E-12
C17   EMU10   BT3315DTHYPU   0.1174   2.15E-09  1.05E-12
D16   EMU8   BT3315DTHYPU   0.093   1.70E-09  8.42E-13
B18   TDO   BT3325CTPU   0.1357   2.49E-09  1.22E-12
A20   AED13   BT3315DTPU   0.1718   3.17E-09  1.51E-12
B20   AED11   BT3315DTPU   0.1583   2.93E-09  1.39E-12
D17   EMU11   BT3315DTHYPU   0.0955   1.75E-09  8.81E-13
C19   AED15   BT3315DTPU   0.1283   2.36E-09  1.16E-12
A21   AED09   BT3315DTPU   0.174   3.21E-09  1.54E-12
C20   AED10   BT3315DTPU   0.1378   2.53E-09  1.26E-12
B21   AED07   BT3315DTPU   0.1588   2.93E-09  1.42E-12
D19   AED14   BT3315DTPU   0.1105   2.01E-09  1.04E-12
C21   AED06   BT3315DTPU   0.1445   2.64E-09  1.33E-12
B22   AED03   BT3315DTPU   0.1665   3.06E-09  1.51E-12
D20   AED12   BT3315DTPU   0.1178   2.14E-09  1.11E-12
A23   AED05   BT3315DTPU   0.1861   3.43E-09  1.67E-12
C22   AED04   BT3315DTPU   0.1485   2.71E-09  1.37E-12
D21   AED08   BT3315DTPU   0.1256   2.29E-09  1.17E-12
B23   AED02   BT3315DTPU   0.1627   3.00E-09  1.44E-12
A24   AED01   BT3315DTPU   0.1927   3.57E-09  1.68E-12
B24   AED00   BT3315DTPU   0.1784   3.29E-09  1.59E-12
C25   AED30   BT3315DTPU   0.1772   3.27E-09  1.57E-12
C26   AED31   BT3315DTPU   0.1873   3.44E-09  1.66E-12
D25   AED28   BT3315DTPU   0.161   2.97E-09  1.47E-12
D26   AED29   BT3315DTPU   0.1818   3.39E-09  1.71E-12
E25   AED26   BT3315DTPU   0.1682   3.14E-09  1.57E-12
E24   AED27   BT3315DTPU   0.1418   2.60E-09  1.29E-12
F26   AED22   BT3315DTPU   0.1743   3.21E-09  1.55E-12
F25   AED24   BT3315DTPU   0.1589   2.91E-09  1.42E-12
F24   AED25   BT3315DTPU   0.1434   2.63E-09  1.29E-12
F23   AED23   BT3315DTPU   0.1237   2.25E-09  1.12E-12
G26   AED18   BT3315DTPU   0.1471   2.70E-09  1.31E-12
G25   AED20   BT3315DTPU   0.1445   2.64E-09  1.30E-12
G24   AED21   BT3315DTPU   0.1401   2.57E-09  1.26E-12
G23   AED19   BT3315DTPU   0.1202   2.20E-09  1.08E-12
H25   AECLKIN   IT33THYPD   0.1487   2.75E-09  1.29E-12
H24   AED16   BT3315DTPU   0.1248   2.30E-09  1.09E-12
H23   AED17   BT3315DTPU   0.1074   1.97E-09  9.56E-13
J25   ASDCASZ   BT3315DTPU   0.1364   2.48E-09  1.17E-12
J24   ASDRASZ   BT3315DTPU   0.1224   2.24E-09  1.03E-12
J23   AECLKOT2   BT3315DTPD   0.1   1.86E-09  8.55E-13
J26   AECLKOT1   BT3315DTPD   0.1448   2.65E-09  1.23E-12
K23   ACE2Z   BT3315DTPU   0.0938   1.72E-09  8.52E-13
K24   ACE1Z   BT3315DTPU   0.1113   2.04E-09  1.02E-12
K25   ACE0Z   BT3315DTPU   0.1259   2.31E-09  1.15E-12
K26   ASDWEZ   BT3315DTPU   0.1406   2.59E-09  1.26E-12
L23   ABE01Z   BT3315DTPU   0.0961   1.75E-09  8.81E-13
L22   AARDY   IT33THYPU   0.0784   1.42E-09  7.32E-13
L24   ABE00Z   BT3315DTPU   0.1071   1.97E-09  9.65E-13
L25   ASDCKE   BT3315DTPU   0.125   2.30E-09  1.12E-12
L26   ACE3Z   BT3315DTPU   0.139   2.56E-09  1.23E-12
M22   APDTZ   BT3315DTPU   0.074   1.34E-09  6.98E-13
M23   AEA04   BT3315DTPD   0.0903   1.64E-09  8.30E-13
M24   AEA03   BT3315DTPD   0.105   1.91E-09  9.64E-13
M25   ABE03Z   BT3315DTPU   0.1201   2.20E-09  1.08E-12
N22   AHOLDAZ   BT3315DTPU   0.0724   1.30E-09  6.85E-13
N23   AEA07   BT3315DTPD   0.1669   3.04E-09  1.52E-12
N24   AEA06   BT3315DTPD   0.1016   1.84E-09  9.39E-13
M26   ABE02Z   BT3315DTPU   0.1409   2.59E-09  1.26E-12
N26   AEA05   BT3315DTPD   0.1326   2.42E-09  1.20E-12
P26   AEA08   BT3315DTPD   0.1329   2.42E-09  1.20E-12
R26   ABE04Z   BT3315DTPU   0.1441   2.64E-09  1.29E-12
P24   AEA09   BT3315DTPD   0.103   1.87E-09  9.43E-13
P23   AEA10   BT3315DTPD   0.0883   1.60E-09  8.14E-13
P22   ABUSREQ0   BT3315DTPU   0.0734   1.33E-09  6.83E-13
R25   ABE05Z   BT3315DTPU   0.1209   2.22E-09  1.07E-12
R24   AEA11   BT3315DTPD   0.1062   1.94E-09  9.60E-13
R23   AEA12   BT3315DTPD   0.0913   1.67E-09  8.28E-13
R22   ASOE3Z   BT3315DTPU   0.0749   1.36E-09  6.97E-13
T25   AEA13   BT3315DTPD   0.1263   2.32E-09  1.11E-12
T24   AEA14   BT3315DTPD   0.1116   2.05E-09  9.87E-13
T23   ABE06Z   BT3315DTPU   0.0944   1.73E-09  8.42E-13
T22   ABE07Z   BT3315DTPU   0.0897   1.64E-09  8.05E-13
U26   AEA15   BT3315DTPD   0.1406   2.61E-09  1.22E-12
U25   AEA16   BT3315DTPD   0.1258   2.32E-09  1.13E-12
U24   AEA17   BT3315DTPD   0.1112   2.05E-09  9.99E-13
U23   AEA22   BT3315DTPD   0.0967   1.77E-09  8.72E-13
V26   AEA19   BT3315DTPD   0.14   2.63E-09  1.28E-12
V25   AEA20   BT3315DTPD   0.1264   2.36E-09  1.16E-12
V24   AEA21   BT3315DTPD   0.1128   2.10E-09  1.03E-12
V23   AEA18   BT3315DTPD   0.0992   1.83E-09  8.94E-13
Y26   AED46   BT3315DTPU   0.1587   2.96E-09  1.36E-12
Y25   AED44   BT3315DTPU   0.1473   2.73E-09  1.27E-12
W24   AHOLDZ   IT33THYPU   0.121   2.23E-09  1.07E-12
W23   AED47   BT3315DTPU   0.1032   1.89E-09  9.35E-13
Y24   AED43   BT3315DTPU   0.1224   2.26E-09  1.08E-12
Y23   AED45   BT3315DTPU   0.1092   2.01E-09  9.76E-13
AA26   AED42   BT3315DTPU   0.1452   2.68E-09  1.28E-12
AA25   AED40   BT3315DTPU   0.1323   2.43E-09  1.19E-12
AA24   AED39   BT3315DTPU   0.1192   2.20E-09  1.06E-12
AA23   AED41   BT3315DTPU   0.1173   2.15E-09  1.05E-12
AB25   AED37   BT3315DTPU   0.1512   2.78E-09  1.34E-12
AB24   AED36   BT3315DTPU   0.1366   2.51E-09  1.22E-12
AC26   AED35   BT3315DTPU   0.172   3.18E-09  1.50E-12
AB23   AED38   BT3315DTPU   0.1216   2.23E-09  1.10E-12
AC25   AED34   BT3315DTPU   0.1562   2.92E-09  1.34E-12
AD26   AED32   BT3315DTPU   0.1733   3.27E-09  1.51E-12
AD25   AED33   BT3315DTPU   0.1573   2.95E-09  1.45E-12
AF24   AED63   BT3315DTPU   0.1698   3.18E-09  1.55E-12
AD23   AED60   BT3315DTPU   0.1332   2.48E-09  1.28E-12
AE23   AED61   BT3315DTPU   0.148   2.77E-09  1.40E-12
AF23   AED62   BT3315DTPU   0.1605   3.02E-09  1.51E-12
AD22   AED59   BT3315DTPU   0.125   2.34E-09  1.22E-12
AE22   AED58   BT3315DTPU   0.1395   2.62E-09  1.34E-12
AC21   AED55   BT3315DTPU   0.107   2.00E-09  1.05E-12
AD21   AED57   BT3315DTPU   0.1222   2.28E-09  1.17E-12
AE21   AED56   BT3315DTPU   0.137   2.55E-09  1.31E-12
AF21   AED54   BT3315DTPU   0.152   2.84E-09  1.42E-12
AC20   AED51   BT3315DTPU   0.1045   1.95E-09  1.02E-12
AD20   AED53   BT3315DTPU   0.1063   1.97E-09  9.86E-13
AE20   AED52   BT3315DTPU   0.1121   2.08E-09  1.04E-12
AF20   AED50   BT3315DTPU   0.1179   2.18E-09  1.08E-12
AC19   AED49   BT3315DTPU   0.1089   2.02E-09  1.01E-12
AD19   AED48   BT3315DTPU   0.1188   2.20E-09  1.09E-12
AE18   VP0D01   BT3325CTHYPD   0.1278   2.36E-09  1.18E-12
AF18   VP0D00   BT3325CTHYPD   0.1427   2.63E-09  1.31E-12
AC17   VP0CTL1   BT3325CTHYPD   0.099   1.83E-09  9.31E-13
AD17   VP0CTL2   BT3325CTHYPD   0.1128   2.08E-09  1.03E-12
AE17   VP0CTL0   BT3325CTHYPD   0.1271   2.35E-09  1.16E-12
AF17   VP0D02   BT3325CTHYPD   0.1412   2.61E-09  1.23E-12
AB16   VP0D07   BT3325CTHYPD   0.0792   1.45E-09  7.33E-13
AC16   VP0D06   BT3325CTHYPD   0.1264   2.33E-09  1.12E-12
AD16   VP0D05   BT3325CTHYPD   0.1533   2.85E-09  1.31E-12
AB15   VP0D11   BT3325CTHYPD   0.0708   1.30E-09  6.40E-13
AC15   VP0D10   BT3325CTHYPD   0.0907   1.66E-09  8.26E-13
AE16   VP0D04   BT3325CTHYPD   0.1271   2.35E-09  1.14E-12
AD15   VP0D09   BT3325CTHYPD   0.1131   2.08E-09  1.02E-12
AB14   VP0D14   BT3325CTHYPD   0.0714   1.29E-09  6.76E-13
AC14   VP0D13   BT3325CTHYPD   0.092   1.68E-09  8.40E-13
AF16   VP0D03   BT3325CTHYPD   0.1438   2.65E-09  1.27E-12
AE15   VP0D08   BT3325CTHYPD   0.13   2.38E-09  1.17E-12
AD14   VP0D12   BT3325CTHYPD   0.1084   1.98E-09  9.80E-13
AF14   VP0CLK0   IT33THYPD   0.1386   2.55E-09  1.24E-12
AF12   VP0CLK1   BT3325CTHYPD   0.1447   2.67E-09  1.29E-12
AB13   VP0D17   BT3325CTHYPD   0.0783   1.44E-09  7.05E-13
AC13   VP0D16   BT3325CTHYPD   0.0933   1.72E-09  8.66E-13
AD13   VP0D15   BT3325CTHYPD   0.107   1.98E-09  1.01E-12
AD12   VP0D18   BT3325CTHYPD   0.1063   1.97E-09  1.00E-12
AB12   VP1D19   BT3325CTHYPD   0.0757   1.38E-09  7.10E-13
AC12   VP0D19   BT3325CTHYPD   0.0976   1.79E-09  8.77E-13
AE11   VP1D15   BT3325CTHYPD   0.1252   2.30E-09  1.12E-12
AD11   VP1D16   BT3325CTHYPD   0.1103   2.02E-09  9.88E-13
AB11   VP1D18   BT3325CTHYPD   0.0801   1.46E-09  7.42E-13
AC11   VP1D17   BT3325CTHYPD   0.0976   1.79E-09  8.82E-13
AF10   VP1CLK1   BT3325CTHYPD   0.1484   2.74E-09  1.32E-12
AC10   VP1D14   BT3325CTHYPD   0.1109   2.04E-09  1.01E-12
AD10   VP1D13   BT3325CTHYPD   0.1261   2.32E-09  1.14E-12
AE9   VP1D10   BT3325CTHYPD   0.1354   2.50E-09  1.23E-12
AD9   VP1D11   BT3325CTHYPD   0.1206   2.22E-09  1.11E-12
AC9   VP1D12   BT3325CTHYPD   0.1032   1.90E-09  9.58E-13
AC8   VP1D09   BT3325CTHYPD   0.0916   1.69E-09  8.54E-13
AF8   VP1CLK0   IT33THYPD   0.154   2.84E-09  1.37E-12
AD8   VP1D08   BT3325CTHYPD   0.1547   2.76E-09  1.30E-12
AE7   VP1D05   BT3325CTHYPD   0.1577   2.93E-09  1.41E-12
AC7   VP1D07   BT3325CTHYPD   0.1305   2.33E-09  1.09E-12
AD7   VP1D06   BT3325CTHYPD   0.122   2.26E-09  1.12E-12
AF6   VP1D01   BT3325CTHYPD   0.1651   3.07E-09  1.51E-12
AF5   VP1D00   BT3325CTHYPD   0.1758   3.27E-09  1.60E-12
AE6   VP1D02   BT3325CTHYPD   0.15   2.78E-09  1.38E-12
AD6   VP1D03   BT3325CTHYPD   0.1356   2.51E-09  1.25E-12
AC6   VP1D04   BT3325CTHYPD   0.1177   2.17E-09  1.10E-12
AF4   VP1CTL0   BT3325CTHYPD   0.1766   3.28E-09  1.58E-12
AE5   VP1CTL1   BT3325CTHYPD   0.1513   2.80E-09  1.39E-12
AE4   CLKMODE1   IT33THYPD   0.1584   2.95E-09  1.42E-12
AD5   VP1CTL2   BT3325CTHYPD   0.1872   3.52E-09  1.62E-12
AC2   CLKIN   IDPECLT   0.1646   3.07E-09  1.46E-12
Y4   AD2   BPCI66T   0.1033   1.92E-09  9.33E-13
AD1   VDAC   BT3325CTHYPD   0.1864   3.52E-09  1.77E-12
AC1   STCLK   IT33THYPD   0.1773   3.33E-09  1.66E-12
W4   AD6   BPCI66T   0.1035   1.90E-09  9.87E-13
Y3   AD0   BPCI66T   0.1276   2.35E-09  1.21E-12
AA2   CLKMODE0   IT33THYPD   0.151   2.80E-09  1.42E-12
W3   AD4   BPCI66T   0.1184   2.17E-09  1.16E-12
Y2   AD3   BPCI66T   0.1431   2.65E-09  1.36E-12
V4   PCBE0Z   BPCI66T   0.0992   1.80E-09  9.63E-13
AA1   AD1   BPCI66T   0.1663   3.09E-09  1.52E-12
U4   AD11   BPCI66T   0.0913   1.68E-09  8.69E-13
V3   AD9   BPCI66T   0.1155   2.16E-09  1.07E-12
W2   AD7   BPCI66T   0.1409   2.63E-09  1.29E-12
T4   XSP_CS   BT3325CTPD   0.0873   1.61E-09  8.50E-13
U3   AD13   BPCI66T   0.1115   2.07E-09  1.05E-12
V2   AD8   BPCI66T   0.1381   2.54E-09  1.29E-12
Y1   AD5   BPCI66T   0.1775   3.29E-09  1.61E-12
T3   AD15   BPCI66T   0.1057   1.93E-09  1.00E-12
R5   XSP_CLK   BT3325CTHYPD   0.0731   1.31E-09  7.11E-13
R4   XSP_DI   IT33TPU   0.0871   1.58E-09  8.37E-13
U2   AD12   BPCI66T   0.1339   2.45E-09  1.24E-12
V1   AD10   BPCI66T   0.1579   2.92E-09  1.45E-12
R3   PSTOPZ   BPCI66T   0.1021   1.86E-09  9.68E-13
P5   XSP_DO   BT3325CTPU   0.0709   1.26E-09  6.93E-13
P4   RESETZ   IT33THY   0.0874   1.58E-09  8.34E-13
T2   PCBE1Z   BPCI66T   0.1346   2.47E-09  1.24E-12
U1   AD14   BPCI66T   0.1603   2.96E-09  1.46E-12
P3   PPAR   BPCI66T   0.1032   1.87E-09  9.86E-13
R2   PSERRZ   BPCI66T   0.1292   2.36E-09  1.21E-12
R1   PPERRZ   BPCI66T   0.1457   2.67E-09  1.34E-12
P1   PDEVSELZ   BPCI66T   0.1348   2.46E-09  1.26E-12
N1   PIRDYZ   BPCI66T   0.136   2.48E-09  1.27E-12
N3   PTRDYZ   BPCI66T   0.1   1.82E-09  9.48E-13
N4   PFRAMEZ   BPCI66T   0.0733   1.32E-09  7.29E-13
M1   PCBE2Z   BPCI66T   0.1347   2.49E-09  1.24E-12
M2   AD17   BPCI66T   0.1201   2.20E-09  1.14E-12
M3   AD16   BPCI66T   0.1055   1.94E-09  9.90E-13
M4   AD18   BPCI66T   0.0894   1.65E-09  8.28E-13
M5   GP0   BT3325CTHYPD   0.0753   1.38E-09  7.15E-13
L2   AD19   BPCI66T   0.1209   2.25E-09  1.11E-12
L3   AD20   BPCI66T   0.1068   1.98E-09  9.96E-13
L4   AD22   BPCI66T   0.0923   1.70E-09  8.70E-13
L5   GP3   BT3325CTHYPD   0.0739   1.35E-09  7.04E-13
K1   AD23   BPCI66T   0.1404   2.61E-09  1.26E-12
K2   AD21   BPCI66T   0.1253   2.32E-09  1.15E-12
K3   PIDSEL   BPCI66T   0.1097   2.02E-09  1.03E-12
K4   AD24   BPCI66T   0.0951   1.74E-09  9.22E-13
J1   AD25   BPCI66T   0.141   2.61E-09  1.32E-12
J2   PCBE3Z   BPCI66T   0.1267   2.33E-09  1.21E-12
J3   AD26   BPCI66T   0.1124   2.06E-09  1.08E-12
J4   AD28   BPCI66T   0.0963   1.76E-09  9.43E-13
H2   AD27   BPCI66T   0.1305   2.43E-09  1.25E-12
G1   AD31   BPCI66T   0.1516   2.83E-09  1.41E-12
H3   AD30   BPCI66T   0.1173   2.17E-09  1.12E-12
H4   PGNTZ   BPCI66T   0.1045   1.92E-09  1.00E-12
G2   AD29   BPCI66T   0.1373   2.55E-09  1.28E-12
F1   PREQZ   BPCI66T   0.1552   2.90E-09  1.44E-12
G3   PRSTZ   BPCI66T   0.1202   2.23E-09  1.15E-12
G4   PINTAZ   BPCI66T   0.1049   1.96E-09  9.81E-13
F2   EXT_INT6   BT3325CTHYPU   0.1385   2.59E-09  1.24E-12
F3   EXT_INT5   BT3325CTHYPU   0.1254   2.32E-09  1.15E-12
E1   EXT_INT7   BT3325CTHYPU   0.1561   2.90E-09  1.41E-12
F4   EXT_INT4   BT3325CTHYPU   0.1061   1.97E-09  1.02E-12
E2   PCI_EN   IT33THYPD   0.1395   2.60E-09  1.30E-12
D3   SDA0   BQ0001THY   0.1356   2.53E-09  1.28E-12
E4   SCL0   BQ0001THY   0.0985   1.86E-09  9.77E-13
| Reserved Pins
|V6   Reserved
|AA3   Reserved
|AD3   Reserved
|AC4   Reserved
|E14   Reserved
|AF3   Reserved
|AB3   Reserved
[Component]   DM642_GNZ
[Manufacturer]  Texas Instruments
[Package]
|Variable  Typ   Min   Max
 R_pkg   0.111578511  0.001847  0.2627
 L_pkg   2.35E-09   4.05E-11  5.38E-09
 C_pkg   2.25E-12   2.44E-14  4.91E-12
[Pin]   signal_name  model_name   R_pin   L_pin   C_pin
C1   PCLK   BPCI66T   0.1695   3.55E-09  3.54E-12
B4   NMI   IT33THYPD   0.1673   3.47E-09  3.20E-12
A4   TINP0   IT33THYPD   0.1825   3.81E-09  3.44E-12
C5   TOUT0   BT3325CTPD   0.1683   3.44E-09  3.18E-12
B5   TOUT1   BT3325CTPU   0.1829   3.73E-09  3.52E-12
A5   TINP1   IT33THYPD   0.1986   4.09E-09  3.78E-12
D6   CLKOUT4   BT3315DTHYPU   0.1719   3.53E-09  3.21E-12
C6   CLKOUT6   BT3315DTHYPU   0.1869   3.83E-09  3.54E-12
C7   VP2CTL2   BT3325CTHYPD   0.1771   3.64E-09  3.29E-12
D7   VP2CTL1   BT3325CTHYPD   0.1645   3.33E-09  3.07E-12
A7   VP2CLK0   IT33THYPD   0.1996   3.97E-09  4.06E-12
D8   VP2D01   BT3325CTHYPD   0.168   3.42E-09  3.29E-12
C8   VP2D00   BT3325CTHYPD   0.1833   3.78E-09  3.54E-12
B8   VP2CTL0   BT3325CTHYPD   0.2011   4.17E-09  3.85E-12
D9   VP2D05   BT3325CTHYPD   0.1639   3.36E-09  3.11E-12
C9   VP2D04   BT3325CTHYPD   0.1881   3.85E-09  3.61E-12
B9   VP2D03   BT3325CTHYPD   0.2035   4.16E-09  3.95E-12
A9   VP2D02   BT3325CTHYPD   0.2285   4.71E-09  4.33E-12
D10   VP2D09   BT3325CTHYPD   0.1919   3.91E-09  3.60E-12
C10   VP2D08   BT3325CTHYPD   0.2078   4.23E-09  3.98E-12
B10   VP2D07   BT3325CTHYPD   0.2235   4.54E-09  4.33E-12
A10   VP2D06   BT3325CTHYPD   0.2393   4.85E-09  4.68E-12
D11   VP2D13   BT3325CTHYPD   0.204   4.12E-09  3.85E-12
E11   VP2D14   BT3325CTHYPD   0.1954   3.93E-09  3.68E-12
C11   VP2D12   BT3325CTHYPD   0.223   4.50E-09  4.27E-12
B11   VP2D11   BT3325CTHYPD   0.2381   4.82E-09  4.58E-12
A11   VP2D10   BT3325CTHYPD   0.2627   5.38E-09  4.91E-12
E12   VP2D18   BT3325CTHYPD   0.2115   4.26E-09  3.93E-12
D12   VP2D17   BT3325CTHYPD   0.2303   4.63E-09  4.41E-12
C12   VP2D16   BT3325CTHYPD   0.2187   4.44E-09  4.17E-12
B12   VP2D15   BT3325CTHYPD   0.2103   4.28E-09  4.06E-12
E13   VP2D19   BT3325CTHYPD   0.1716   3.42E-09  3.26E-12
A13   VP2CLK1   BT3325CTHYPD   0.2247   4.50E-09  4.43E-12
A15   EMU0   BT3315DTHYPU   0.2261   4.52E-09  4.44E-12
A16   TCK   IT33THYPU   0.2364   4.73E-09  4.68E-12
C14   EMU1   BT3315DTHYPU   0.1976   3.98E-09  3.78E-12
B15   EMU2   BT3315DTHYPU   0.2239   4.57E-09  4.35E-12
C15   EMU3   BT3315DTHYPU   0.2123   4.36E-09  4.05E-12
D14   TRSTZ   IT33THYPD   0.1813   3.67E-09  3.43E-12
B16   EMU5   BT3315DTHYPU   0.2164   4.46E-09  4.15E-12
A17   EMU7   BT3315DTHYPU   0.2223   4.54E-09  4.39E-12
C16   EMU6   BT3315DTHYPU   0.191   3.95E-09  3.89E-12
D15   EMU4   BT3315DTHYPU   0.1768   3.62E-09  3.39E-12
E15   TMS   IT33THYPU   0.1623   3.32E-09  3.02E-12
B17   EMU9   BT3315DTHYPU   0.1985   4.10E-09  3.92E-12
A18   TDI   IT33THYPU   0.2137   4.40E-09  4.17E-12
C17   EMU10   BT3315DTHYPU   0.1791   3.69E-09  3.43E-12
D16   EMU8   BT3315DTHYPU   0.1554   3.19E-09  2.92E-12
B18   TDO   BT3325CTPU   0.1886   3.93E-09  3.56E-12
A20   AED13   BT3315DTPU   0.213   4.35E-09  4.21E-12
B20   AED11   BT3315DTPU   0.1915   4.00E-09  3.66E-12
D17   EMU11   BT3315DTHYPU   0.1479   3.04E-09  2.81E-12
C19   AED15   BT3315DTPU   0.1748   3.64E-09  3.33E-12
A21   AED09   BT3315DTPU   0.2084   4.32E-09  4.13E-12
C20   AED10   BT3315DTPU   0.1779   3.70E-09  3.48E-12
B21   AED07   BT3315DTPU   0.1939   4.06E-09  3.71E-12
D19   AED14   BT3315DTPU   0.1442   2.99E-09  2.76E-12
C21   AED06   BT3315DTPU   0.1698   3.57E-09  3.27E-12
B22   AED03   BT3315DTPU   0.197   4.19E-09  3.76E-12
D20   AED12   BT3315DTPU   0.1424   2.99E-09  2.74E-12
A23   AED05   BT3315DTPU   0.2017   4.18E-09  4.14E-12
C22   AED04   BT3315DTPU   0.1637   3.43E-09  3.30E-12
D21   AED08   BT3315DTPU   0.1414   2.95E-09  2.85E-12
B23   AED02   BT3315DTPU   0.1795   3.78E-09  3.62E-12
A24   AED01   BT3315DTPU   0.1949   4.13E-09  3.94E-12
B24   AED00   BT3315DTPU   0.1806   3.85E-09  3.65E-12
C25   AED30   BT3315DTPU   0.1751   3.73E-09  3.56E-12
C26   AED31   BT3315DTPU   0.1812   3.84E-09  3.71E-12
D25   AED28   BT3315DTPU   0.1588   3.41E-09  3.19E-12
D26   AED29   BT3315DTPU   0.1535   3.32E-09  2.98E-12
E25   AED26   BT3315DTPU   0.1392   3.01E-09  2.85E-12
E24   AED27   BT3315DTPU   0.1235   2.66E-09  2.59E-12
F26   AED22   BT3315DTPU   0.1359   2.90E-09  2.87E-12
F25   AED24   BT3315DTPU   0.1218   2.60E-09  2.57E-12
F24   AED25   BT3315DTPU   0.1081   2.33E-09  2.24E-12
F23   AED23   BT3315DTPU   0.09372   2.03E-09  1.90E-12
G26   AED18   BT3315DTPU   0.1307   2.79E-09  2.74E-12
G25   AED20   BT3315DTPU   0.117   2.51E-09  2.43E-12
G24   AED21   BT3315DTPU   0.1038   2.24E-09  2.10E-12
G23   AED19   BT3315DTPU   0.08718   1.87E-09  1.77E-12
H25   AECLKIN   IT33THYPD   0.1085   2.26E-09  2.32E-12
H24   AED16   BT3315DTPU   0.09543   2.00E-09  2.00E-12
H23   AED17   BT3315DTPU   0.07998   1.72E-09  1.65E-12
J25   ASDCASZ   BT3315DTPU   0.1025   2.19E-09  2.18E-12
J24   ASDRASZ   BT3315DTPU   0.08962   1.87E-09  1.94E-12
J23   AECLKOT2   BT3315DTPD   0.06798   1.40E-09  1.53E-12
J26   AECLKOT1   BT3315DTPD   0.09615   1.98E-09  2.17E-12
K23   ACE2Z   BT3315DTPU   0.04876   1.01E-09  1.07E-12
K24   ACE1Z   BT3315DTPU   0.0604   1.28E-09  1.32E-12
K25   ACE0Z   BT3315DTPU   0.07216   1.52E-09  1.59E-12
K26   ASDWEZ   BT3315DTPU   0.08386   1.76E-09  1.85E-12
L23   ABE01Z   BT3315DTPU   0.04507   9.45E-10  9.91E-13
L22   AARDY   IT33THYPU   0.02986   6.45E-10  6.36E-13
L24   ABE00Z   BT3315DTPU   0.05386   1.14E-09  1.17E-12
L25   ASDCKE   BT3315DTPU   0.06558   1.39E-09  1.41E-12
L26   ACE3Z   BT3315DTPU   0.07756   1.65E-09  1.63E-12
M22   APDTZ   BT3315DTPU   0.01512   3.11E-10  3.27E-13
M23   AEA04   BT3315DTPD   0.02738   5.70E-10  5.90E-13
M24   AEA03   BT3315DTPD   0.01819   3.70E-10  3.93E-13
M25   ABE03Z   BT3315DTPU   0.01965   3.98E-10  4.08E-13
N22   AHOLDAZ   BT3315DTPU   0.02843   6.39E-10  5.35E-13
N23   AEA07   BT3315DTPD   0.04193   9.12E-10  8.78E-13
N24   AEA06   BT3315DTPD   0.05535   1.19E-09  1.19E-12
M26   ABE02Z   BT3315DTPU   0.09055   1.89E-09  1.99E-12
N26   AEA05   BT3315DTPD   0.08206   1.74E-09  1.81E-12
P26   AEA08   BT3315DTPD   0.08239   1.74E-09  1.80E-12
R26   ABE04Z   BT3315DTPU   0.09177   1.91E-09  2.01E-12
P24   AEA09   BT3315DTPD   0.05887   1.25E-09  1.28E-12
P23   AEA10   BT3315DTPD   0.04708   1.04E-09  9.24E-13
P22   ABUSREQ0   BT3315DTPU   0.03785   8.32E-10  7.51E-13
R25   ABE05Z   BT3315DTPU   0.07692   1.62E-09  1.68E-12
R24   AEA11   BT3315DTPD   0.06489   1.36E-09  1.41E-12
R23   AEA12   BT3315DTPD   0.05301   1.12E-09  1.13E-12
R22   ASOE3Z   BT3315DTPU   0.0412   8.50E-10  8.74E-13
T25   AEA13   BT3315DTPD   0.08306   1.70E-09  1.78E-12
T24   AEA14   BT3315DTPD   0.07127   1.53E-09  1.50E-12
T23   ABE06Z   BT3315DTPU   0.05943   1.28E-09  1.24E-12
T22   ABE07Z   BT3315DTPU   0.04759   1.04E-09  9.48E-13
U26   AEA15   BT3315DTPD   0.1015   2.20E-09  2.03E-12
U25   AEA16   BT3315DTPD   0.08964   1.93E-09  1.87E-12
U24   AEA17   BT3315DTPD   0.07784   1.69E-09  1.60E-12
U23   AEA22   BT3315DTPD   0.06592   1.42E-09  1.36E-12
V26   AEA19   BT3315DTPD   0.1074   2.31E-09  2.19E-12
V25   AEA20   BT3315DTPD   0.09563   2.03E-09  2.03E-12
V24   AEA21   BT3315DTPD   0.08386   1.78E-09  1.78E-12
V23   AEA18   BT3315DTPD   0.07183   1.53E-09  1.53E-12
Y26   AED46   BT3315DTPU   0.123   2.57E-09  2.59E-12
Y25   AED44   BT3315DTPU   0.1208   2.57E-09  2.53E-12
W24   AHOLDZ   IT33THYPU   0.103   2.20E-09  2.17E-12
W23   AED47   BT3315DTPU   0.09144   1.90E-09  1.95E-12
Y24   AED43   BT3315DTPU   0.09639   2.00E-09  2.07E-12
Y23   AED45   BT3315DTPU   0.08498   1.83E-09  1.79E-12
AA26   AED42   BT3315DTPU   0.1264   2.67E-09  2.68E-12
AA25   AED40   BT3315DTPU   0.1146   2.44E-09  2.44E-12
AA24   AED39   BT3315DTPU   0.1032   2.19E-09  2.19E-12
AA23   AED41   BT3315DTPU   0.09278   1.99E-09  1.94E-12
AB25   AED37   BT3315DTPU   0.1359   2.86E-09  2.86E-12
AB24   AED36   BT3315DTPU   0.1239   2.65E-09  2.61E-12
AC26   AED35   BT3315DTPU   0.142   2.99E-09  2.98E-12
AB23   AED38   BT3315DTPU   0.1124   2.41E-09  2.34E-12
AC25   AED34   BT3315DTPU   0.1318   2.84E-09  2.65E-12
AD26   AED32   BT3315DTPU   0.1458   3.10E-09  2.97E-12
AD25   AED33   BT3315DTPU   0.1371   2.96E-09  2.79E-12
AF24   AED63   BT3315DTPU   0.1416   3.12E-09  2.80E-12
AD23   AED60   BT3315DTPU   0.1229   2.67E-09  2.52E-12
AE23   AED61   BT3315DTPU   0.1373   3.00E-09  2.80E-12
AF23   AED62   BT3315DTPU   0.1279   2.76E-09  2.65E-12
AD22   AED59   BT3315DTPU   0.1184   2.55E-09  2.46E-12
AE22   AED58   BT3315DTPU   0.129   2.76E-09  2.66E-12
AC21   AED55   BT3315DTPU   0.08988   1.93E-09  1.88E-12
AD21   AED57   BT3315DTPU   0.1007   2.18E-09  2.07E-12
AE21   AED56   BT3315DTPU   0.1093   2.43E-09  2.07E-12
AF21   AED54   BT3315DTPU   0.1187   2.65E-09  2.25E-12
AC20   AED51   BT3315DTPU   0.09328   2.05E-09  1.82E-12
AD20   AED53   BT3315DTPU   0.1183   2.58E-09  2.39E-12
AE20   AED52   BT3315DTPU   0.1216   2.59E-09  2.52E-12
AF20   AED50   BT3315DTPU   0.09906   2.16E-09  3.40E-12
AC19   AED49   BT3315DTPU   0.08991   1.88E-09  1.92E-12
AD19   AED48   BT3315DTPU   0.103   2.17E-09  2.18E-12
AE18   VP0D01   BT3325CTHYPD   0.09311   2.01E-09  1.90E-12
AF18   VP0D00   BT3325CTHYPD   0.1032   2.23E-09  2.08E-12
AC17   VP0CTL1   BT3325CTHYPD   0.06316   1.36E-09  1.29E-12
AD17   VP0CTL2   BT3325CTHYPD   0.07514   1.62E-09  1.55E-12
AE17   VP0CTL0   BT3325CTHYPD   0.08605   1.86E-09  1.78E-12
AF17   VP0D02   BT3325CTHYPD   0.09961   2.16E-09  1.96E-12
AB16   VP0D07   BT3325CTHYPD   0.04359   9.41E-10  8.56E-13
AC16   VP0D06   BT3325CTHYPD   0.04748   1.03E-09  9.25E-13
AD16   VP0D05   BT3325CTHYPD   0.05847   1.27E-09  1.19E-12
AB15   VP0D11   BT3325CTHYPD   0.05283   1.17E-09  1.03E-12
AC15   VP0D10   BT3325CTHYPD   0.04028   8.95E-10  7.68E-13
AE16   VP0D04   BT3325CTHYPD   0.0752   1.64E-09  1.51E-12
AD15   VP0D09   BT3325CTHYPD   0.06037   1.32E-09  1.23E-12
AB14   VP0D14   BT3325CTHYPD   0.05532   1.20E-09  1.15E-12
AC14   VP0D13   BT3325CTHYPD   0.05336   1.18E-09  1.05E-12
AF16   VP0D03   BT3325CTHYPD   0.1001   2.15E-09  2.05E-12
AE15   VP0D08   BT3325CTHYPD   0.0811   1.75E-09  1.67E-12
AD14   VP0D12   BT3325CTHYPD   0.0611   1.30E-09  1.28E-12
AF14   VP0CLK0   IT33THYPD   0.08342   1.71E-09  1.79E-12
AF12   VP0CLK1   BT3325CTHYPD   0.06122   1.27E-09  1.36E-12
AB13   VP0D17   BT3325CTHYPD   0.05761   1.21E-09  1.28E-12
AC13   VP0D16   BT3325CTHYPD   0.05522   1.18E-09  1.21E-12
AD13   VP0D15   BT3325CTHYPD   0.06896   1.47E-09  1.51E-12
AD12   VP0D18   BT3325CTHYPD   0.06935   1.48E-09  1.52E-12
AB12   VP1D19   BT3325CTHYPD   0.04538   1.00E-09  9.46E-13
AC12   VP0D19   BT3325CTHYPD   0.0618   1.36E-09  1.27E-12
AE11   VP1D15   BT3325CTHYPD   0.0772   1.64E-09  1.68E-12
AD11   VP1D16   BT3325CTHYPD   0.06549   1.36E-09  1.44E-12
AB11   VP1D18   BT3325CTHYPD   0.04881   1.05E-09  1.04E-12
AC11   VP1D17   BT3325CTHYPD   0.05643   1.21E-09  1.18E-12
AF10   VP1CLK1   BT3325CTHYPD   0.09702   1.93E-09  2.10E-12
AC10   VP1D14   BT3325CTHYPD   0.07778   1.65E-09  1.81E-12
AD10   VP1D13   BT3325CTHYPD   0.09011   1.94E-09  1.99E-12
AE9   VP1D10   BT3325CTHYPD   0.07556   1.63E-09  1.65E-12
AD9   VP1D11   BT3325CTHYPD   0.08104   1.74E-09  1.78E-12
AC9   VP1D12   BT3325CTHYPD   0.06988   1.52E-09  1.48E-12
AC8   VP1D09   BT3325CTHYPD   0.07397   1.58E-09  1.60E-12
AF8   VP1CLK0   IT33THYPD   0.1186   2.45E-09  2.62E-12
AD8   VP1D08   BT3325CTHYPD   0.1188   2.48E-09  2.53E-12
AE7   VP1D05   BT3325CTHYPD   0.1092   2.31E-09  2.32E-12
AC7   VP1D07   BT3325CTHYPD   0.08554   1.85E-09  1.85E-12
AD7   VP1D06   BT3325CTHYPD   0.1025   2.22E-09  2.18E-12
AF6   VP1D01   BT3325CTHYPD   0.1293   2.78E-09  2.79E-12
AF5   VP1D00   BT3325CTHYPD   0.141   3.06E-09  2.93E-12
AE6   VP1D02   BT3325CTHYPD   0.1175   2.57E-09  2.48E-12
AD6   VP1D03   BT3325CTHYPD   0.1059   2.31E-09  2.24E-12
AC6   VP1D04   BT3325CTHYPD   0.09416   2.05E-09  2.01E-12
AF4   VP1CTL0   BT3325CTHYPD   0.1458   3.16E-09  3.04E-12
AE5   VP1CTL1   BT3325CTHYPD   0.136   2.95E-09  2.91E-12
AE4   CLKMODE1   IT33THYPD   0.1296   2.86E-09  2.64E-12
AD5   VP1CTL2   BT3325CTHYPD   0.1457   3.12E-09  2.96E-12
AC2   CLKIN   IDPECLT   0.1335   2.67E-09  2.29E-12
Y4   AD2   BPCI66T   0.06144   1.27E-09  1.32E-12
AD1   VDAC   BT3325CTHYPD   0.1272   2.74E-09  2.66E-12
AC1   STCLK   IT33THYPD   0.1178   2.60E-09  2.37E-12
W4   AD6   BPCI66T   0.05967   1.30E-09  1.29E-12
Y3   AD0   BPCI66T   0.07939   1.75E-09  1.66E-12
AA2   CLKMODE0   IT33THYPD   0.09906   2.17E-09  2.04E-12
W3   AD4   BPCI66T   0.0695   1.52E-09  1.50E-12
Y2   AD3   BPCI66T   0.08944   2.03E-09  1.70E-12
V4   PCBE0Z   BPCI66T   0.04959   1.12E-09  9.62E-13
AA1   AD1   BPCI66T   0.1046   2.25E-09  2.16E-12
U4   AD11   BPCI66T   0.0409   9.03E-10  8.61E-13
V3   AD9   BPCI66T   0.06062   1.35E-09  1.23E-12
W2   AD7   BPCI66T   0.07874   1.73E-09  1.53E-12
T4   XSP_CS   BT3325CTPD   0.03328   7.62E-10  6.09E-13
U3   AD13   BPCI66T   0.05242   1.17E-09  1.02E-12
V2   AD8   BPCI66T   0.07134   1.56E-09  1.44E-12
Y1   AD5   BPCI66T   0.1037   2.19E-09  2.14E-12
T3   AD15   BPCI66T   0.04306   9.77E-10  8.02E-13
R5   XSP_CLK   BT3325CTHYPD   0.01076   2.41E-10  2.07E-13
R4   XSP_DI   IT33TPU   0.02283   5.10E-10  4.42E-13
U2   AD12   BPCI66T   0.06139   1.35E-09  1.23E-12
V1   AD10   BPCI66T   0.08047   1.71E-09  1.66E-12
R3   PSTOPZ   BPCI66T   0.03397   7.71E-10  6.25E-13
P5   XSP_DO   BT3325CTPU   0.001847  4.05E-11  2.44E-14
P4   RESETZ   IT33THY   0.03695   8.40E-10  7.26E-13
T2   PCBE1Z   BPCI66T   0.0773   1.72E-09  1.59E-12
U1   AD14   BPCI66T   0.09881   2.09E-09  2.13E-12
P3   PPAR   BPCI66T   0.05249   1.13E-09  1.16E-12
R2   PSERRZ   BPCI66T   0.07593   1.60E-09  1.71E-12
R1   PPERRZ   BPCI66T   0.08081   1.71E-09  1.80E-12
P1   PDEVSELZ   BPCI66T   0.08016   1.72E-09  1.77E-12
N1   PIRDYZ   BPCI66T   0.07788   1.67E-09  1.75E-12
N3   PTRDYZ   BPCI66T   0.05455   1.23E-09  1.09E-12
N4   PFRAMEZ   BPCI66T   0.04677   1.04E-09  9.19E-13
M1   PCBE2Z   BPCI66T   0.08441   1.80E-09  1.87E-12
M2   AD17   BPCI66T   0.07279   1.55E-09  1.60E-12
M3   AD16   BPCI66T   0.06113   1.31E-09  1.34E-12
M4   AD18   BPCI66T   0.04961   1.09E-09  1.00E-12
M5   GP0   BT3325CTHYPD   0.0417   9.07E-10  8.11E-13
L2   AD19   BPCI66T   0.07932   1.70E-09  1.69E-12
L3   AD20   BPCI66T   0.06685   1.46E-09  1.42E-12
L4   AD22   BPCI66T   0.05546   1.20E-09  1.17E-12
L5   GP3   BT3325CTHYPD   0.04416   9.58E-10  8.94E-13
K1   AD23   BPCI66T   0.0573   1.20E-09  1.16E-12
K2   AD21   BPCI66T   0.05557   1.19E-09  1.12E-12
K3   PIDSEL   BPCI66T   0.05361   1.17E-09  1.06E-12
K4   AD24   BPCI66T   0.05188   1.12E-09  1.03E-12
J1   AD25   BPCI66T   0.09711   2.06E-09  1.96E-12
J2   PCBE3Z   BPCI66T   0.09412   2.03E-09  1.88E-12
J3   AD26   BPCI66T   0.08232   1.77E-09  1.68E-12
J4   AD28   BPCI66T   0.07043   1.54E-09  1.38E-12
H2   AD27   BPCI66T   0.1007   2.18E-09  1.99E-12
G1   AD31   BPCI66T   0.1195   2.52E-09  2.50E-12
H3   AD30   BPCI66T   0.07266   1.59E-09  1.39E-12
H4   PGNTZ   BPCI66T   0.07592   1.66E-09  1.39E-12
G2   AD29   BPCI66T   0.112   2.40E-09  2.20E-12
F1   PREQZ   BPCI66T   0.1304   2.73E-09  2.68E-12
G3   PRSTZ   BPCI66T   0.1004   2.14E-09  1.97E-12
G4   PINTAZ   BPCI66T   0.08877   1.89E-09  1.73E-12
F2   EXT_INT6   BT3325CTHYPU   0.1179   2.53E-09  2.29E-12
F3   EXT_INT5   BT3325CTHYPU   0.106   2.25E-09  2.09E-12
E1   EXT_INT7   BT3325CTHYPU   0.1355   2.85E-09  2.69E-12
F4   EXT_INT4   BT3325CTHYPU   0.09476   2.01E-09  1.85E-12
E2   PCI_EN   IT33THYPD   0.126   2.65E-09  2.49E-12
D3   SDA0   BQ0001THY   0.1305   2.77E-09  2.57E-12
E4   SCL0   BQ0001THY   0.1039   2.18E-09  2.01E-12
| Models and submodels in the file (14): BPCI66T (I/O), IT33TPU (Input), IT33THY (Input), IT33THYPD (Input), IT33THYPU (Input), BT3315DTPU (I/O), BT3315DTPD (I/O), BT3315DTHYPU (I/O), BT3325CTPD (I/O), BT3325CTPU (I/O), BT3325CTHYPD (I/O), BT3325CTHYPU (I/O), IDPECLT (Input), BQ0001THY (I/O)
