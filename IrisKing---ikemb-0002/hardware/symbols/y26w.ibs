| y26w.ibs * IBIS 3.2 Model
| 256Meg SDRAM
| Part Number   VDD/VDDQ   Architecture   Package
| MT48LC8M32B2TG   3.3V/3.3V   8 Meg x 32   86-pin TSOP
| MT48LC8M32B2P   3.3V/3.3V   8 Meg x 32   86-pin TSOP (lead free)
| MT48LC8M32B2F5   3.3V/3.3V   8 Meg x 32   90-ball FBGA
| MT48LC8M32B2B5   3.3V/3.3V   8 Meg x 32   90-ball FBGA (lead free)
[IBIS Ver]   3.2
[File name]   y26w.ibs
[File rev]   1.2
[Date]   01/27/2005
[Source]   From silicon level SPICE model at Micron Technology, Inc.
   Micron Technology, Inc.
   8000 S. Federal Way
   P.O. Box 6
   Boise ID 83707-0006
[Notes]
   For component MT48LC8M32B2P use the MT48LC8M32B2TG model.
   For component MT48LC8M32B2B5 use the MT48LC8M32B2F5 model.
   Rev 1.0: 11/21/2003
   - initial file creation
   Rev 1.1: 12/19/2003
   - Added package RLC values
   - Updated c_comp values on all models
   - DQ models updated due to c_comp change
   Rev 1.2: 01/27/2005
   - Added notes for the MT48LC8M32B2P and MT48LC8M32B2B5
   components.
   For support, email modelsupport@micron.com.
[Disclaimer]  This software code and all associated documentation, comments
              or other information (collectively "Software") is provided
              "AS IS" without warranty of any kind. MICRON TECHNOLOGY, INC.
              ("MTI") EXPRESSLY DISCLAIMS ALL WARRANTIES EXPRESS OR IMPLIED,
              INCLUDING BUT NOT LIMITED TO, NONINFRINGEMENT OF THIRD PARTY
              RIGHTS, AND ANY IMPLIED WARRANTIES OF MERCHANTABILITY OR FITNESS
              FOR ANY PARTICULAR PURPOSE. MTI DOES NOT WARRANT THAT THE
              SOFTWARE WILL MEET YOUR REQUIREMENTS, OR THAT THE OPERATION OF
              THE SOFTWARE WILL BE UNINTERRUPTED OR ERROR-FREE. FURTHERMORE,
              MTI DOES NOT MAKE ANY REPRESENTATIONS REGARDING THE USE OR THE
              RESULTS OF THE USE OF THE SOFTWARE IN TERMS OF ITS CORRECTNESS,
              ACCURACY, RELIABILITY, OR OTHERWISE. THE ENTIRE RISK ARISING OUT
              OF USE OR PERFORMANCE OF THE SOFTWARE REMAINS WITH YOU. IN NO
              EVENT SHALL MTI, ITS AFFILIATED COMPANIES OR THEIR SUPPLIERS BE
              LIABLE FOR ANY DIRECT, INDIRECT, CONSEQUENTIAL, INCIDENTAL, OR
              SPECIAL DAMAGES (INCLUDING, WITHOUT LIMITATION, DAMAGES FOR LOSS
              OF PROFITS, BUSINESS INTERRUPTION, OR LOSS OF INFORMATION)
              ARISING OUT OF YOUR USE OF OR INABILITY TO USE THE SOFTWARE,
              EVEN IF MTI HAS BEEN ADVISED OF THE POSSIBILITY OF SUCH DAMAGES.
              Because some jurisdictions prohibit the exclusion or limitation
              of liability for consequential or incidental damages, the above
              limitation may not apply to you.
[Copyright]   Copyright 2005 Micron Technology, Inc. All Rights Reserved.
|   COMPONENT: MT48LC8M32B2TG
[Component]   MT48LC8M32B2TG
[Manufacturer]   Micron Technology, Inc.
[Package]   | 86-pin TSOP
|variable   typ   min   max
R_pkg   102.8m   20.64m   185.0m
L_pkg   4.74nH   2.67nH   6.82nH
C_pkg   0.82pF   0.52pF   1.13pF
[Pin]  signal_name   model_name  R_pin   L_pin   C_pin
1   VDD   POWER   91.92m   5.35nH   0.91pF
2   DQ0   dqbuff   42.51m   5.11nH   1.13pF
3   VDDQ   POWER   35.17m   3.87nH   1.03pF
4   DQ1   dqbuff   35.02m   4.03nH   0.92pF
5   DQ2   dqbuff   31.63m   3.67nH   0.82pF
6   VSSQ   GND   29.12m   3.95nH   0.75pF
7   DQ3   dqbuff   24.71m   2.99nH   0.67pF
8   DQ4   dqbuff   20.66m   2.67nH   0.52pF
9   VDDQ   POWER   31.70m   3.39nH   0.85pF
10   DQ5   dqbuff   34.53m   3.83nH   0.96pF
11   DQ6   dqbuff   35.13m   3.93nH   0.95pF
12   VSSQ   GND   91.92m   5.35nH   0.94pF
13   DQ7   dqbuff   34.38m   3.87nH   0.92pF
14   NC   NC
15   VDD   POWER   28.31m   3.30nH   0.41pF
16   DQM0   inbuff   29.96m   3.47nH   0.82pF
17   WE#   inbuff2   27.66m   3.46nH   0.76pF
18   CAS#   inbuff   27.49m   3.42nH   0.75pF
19   RAS#   inbuff   39.70m   4.63nH   0.74pF
20   CS#   inbuff   28.06m   3.47nH   0.74pF
21   A11   inbuff   27.66m   3.46nH   0.73pF
22   BA0   inbuff   27.64m   3.43nH   0.74pF
23   BA1   inbuff   28.10m   3.49nH   0.75pF
24   A10   inbuff   28.82m   3.48nH   0.77pF
25   A0   inbuff   29.70m   3.44nH   0.79pF
26   A1   inbuff   30.15m   3.49nH   0.80pF
27   A2   inbuff   30.46m   3.53nH   0.81pF
28   DQM2   inbuff   30.51m   3.52nH   0.83pF
29   VDD   POWER   38.99m   4.64nH   0.87pF
30   NC   NC
31   DQ16   dqbuff   34.94m   3.75nH   0.93pF
32   VSSQ   GND   43.75m   5.88nH   0.94pF
33   DQ17   dqbuff   35.46m   3.90nH   0.95pF
34   DQ18   dqbuff   35.17m   3.94nH   0.96pF
35   VDDQ   POWER   31.53m   3.54nH   0.85pF
36   DQ19   dqbuff   20.64m   2.67nH   0.52pF
37   DQ20   dqbuff   24.80m   2.99nH   0.67pF
38   VSSQ   GND   42.22m   5.82nH   0.75pF
39   DQ21   dqbuff   31.78m   3.66nH   0.82pF
40   DQ22   dqbuff   36.03m   4.10nH   0.92pF
41   VDDQ   POWER   43.12m   5.89nH   1.03pF
42   DQ23   dqbuff   43.37m   5.21nH   1.13pF
43   VDD   POWER   27.96m   4.11nH   0.91pF
44   VSS   GND   91.92m   5.35nH   0.91pF
45   DQ24   dqbuff   41.74m   5.15nH   1.13pF
46   VSSQ   GND   31.34m   3.63nH   1.03pF
47   DQ25   dqbuff   34.57m   4.05nH   0.91pF
48   DQ26   dqbuff   31.26m   3.61nH   0.82pF
49   VDDQ   POWER   35.06m   3.85nH   0.74pF
50   DQ27   dqbuff   24.62m   2.99nH   0.67pF
51   DQ28   dqbuff   20.77m   2.72nH   0.52pF
52   VSSQ   GND   184.6m   7.53nH   0.87pF
53   DQ29   dqbuff   35.43m   3.92nH   0.97pF
54   DQ30   dqbuff   35.73m   3.82nH   0.95pF
55   VDDQ   POWER   28.38m   3.33nH   0.94pF
56   DQ31   dqbuff   34.26m   3.90nH   0.93pF
57   NC   NC
58   VSS   GND   91.92m   5.35nH   0.87pF
59   DQM3   inbuff   30.85m   3.60nH   0.83pF
60   A3   inbuff   30.66m   3.61nH   0.82pF
61   A4   inbuff   30.41m   3.49nH   0.81pF
62   A5   inbuff   29.71m   3.52nH   0.79pF
63   A6   inbuff   28.74m   3.51nH   0.78pF
64   A7   inbuff   27.88m   3.49nH   0.75pF
65   A8   inbuff   27.83m   3.49nH   0.74pF
66   A9   inbuff   27.77m   3.51nH   0.73pF
67   CKE   clkbuff   27.78m   3.48nH   0.73pF
68   CLK   clkbuff   28.06m   3.48nH   0.74pF
69   NC   NC
70   NC   NC
71   DQM1   inbuff   30.04m   3.57nH   0.82pF
72   VSS   GND   91.92m   5.35nH   0.41pF
73   NC   NC
74   DQ8   dqbuff   34.69m   3.85nH   0.92pF
75   VDDQ   POWER   34.54m   3.91nH   0.93pF
76   DQ9   dqbuff   36.11m   3.95nH   0.95pF
77   DQ10   dqbuff   35.62m   3.93nH   0.97pF
78   VSSQ   GND   21.45m   2.61nH   0.53pF
79   DQ11   dqbuff   28.17m   3.47nH   0.86pF
80   DQ12   dqbuff   26.78m   3.04nH   0.67pF
81   VDDQ   POWER   35.53m   3.91nH   0.75pF
82   DQ13   dqbuff   38.62m   3.77nH   0.82pF
83   DQ14   dqbuff   53.10m   4.39nH   0.92pF
84   VSSQ   GND   28.17m   3.47nH   1.03pF
85   DQ15   dqbuff   185.0m   6.82nH   1.12pF
86   VSS   GND   91.92m   5.35nH   0.91pF
|   COMPONENT: MT48LC8M32B2F5
[Component]   MT48LC8M32B2F5
[Manufacturer]   Micron Technology, Inc.
[Package]   | 90-ball FBGA
| variable   typ   min   max
R_pkg   68.92m   31.79m   106.0m
L_pkg   2.40nH   1.25nH   3.55nH
C_pkg   0.63pF   0.41pF   0.86pF
[Pin]  signal_name   model_name  R_pin   L_pin   C_pin
A1   DQ26   dqbuff   31.79m   1.37nH   0.43pF
A2   DQ24   dqbuff   46.12m   1.82nH   0.54pF
A3   VSS   GND   25.14m   1.09nH   8.32pF
A7   VDD   POWER   35.26m   1.80nH   8.85pF
A8   DQ23   dqbuff   39.44m   1.72nH   0.55pF
A9   DQ21   dqbuff   54.52m   2.17nH   0.42pF
B1   DQ28   dqbuff   98.70m   3.45nH   0.41pF
B2   VDDQ   POWER   46.63m   1.80nH   10.4pF
B3   VSSQ   GND   34.05m   1.60nH   10.8pF
B7   VDDQ   POWER   46.63m   1.80nH   10.4pF
B8   VSSQ   GND   48.24m   1.72nH   10.8pF
B9   DQ19   dqbuff   47.75m   1.96nH   0.41pF
C1   VSSQ   GND   66.29m   2.94nH   10.8pF
C2   DQ27   dqbuff   65.63m   2.14nH   0.46pF
C3   DQ25   dqbuff   36.89m   1.46nH   0.47pF
C7   DQ22   dqbuff   52.82m   2.00nH   0.46pF
C8   DQ20   dqbuff   40.89m   1.90nH   0.48pF
C9   VDDQ   POWER   46.63m   1.80nH   10.4pF
D1   VSSQ   GND   26.27m   1.18nH   10.8pF
D2   DQ29   dqbuff   78.73m   2.48nH   0.66pF
D3   DQ30   dqbuff   32.82m   1.64nH   0.86pF
D7   DQ17   dqbuff   35.57m   1.59nH   0.85pF
D8   DQ18   dqbuff   38.41m   1.75nH   0.61pF
D9   VDDQ   POWER   64.43m   2.94nH   10.4pF
E1   VDDQ   POWER   33.18m   1.33nH   10.4pF
E2   DQ31   dqbuff   33.90m   1.55nH   0.72pF
E3   NC   NC
E7   NC   NC
E8   DQ16   dqbuff   66.11m   2.36nH   0.70pF
E9   VSSQ   GND   70.39m   2.86nH   10.8pF
F1   VSS   GND   25.14m   1.09nH   8.32pF
F2   DQM3   inbuff   41.62m   1.72nH   0.70pF
F3   A3   inbuff   75.73m   2.25nH   0.84pF
F7   A2   inbuff   51.22m   1.66nH   0.73pF
F8   DQM2   inbuff   67.35m   2.27nH   0.68pF
F9   VDD   POWER   35.26m   1.80nH   8.85pF
G1   A4   inbuff   85.37m   3.05nH   0.61pF
G2   A5   inbuff   45.47m   1.55nH   0.69pF
G3   A6   inbuff   68.18m   2.22nH   0.79pF
G7   A10   inbuff   77.88m   2.39nH   0.86pF
G8   A0   inbuff   88.70m   2.71nH   0.46pF
G9   A1   inbuff   87.11m   2.73nH   0.78pF
H1   A7   inbuff   66.39m   2.23nH   0.56pF
H2   A8   inbuff   90.27m   2.79nH   0.62pF
H3   NC   NC
H7   NC   NC
H8   BA1   inbuff   56.82m   1.87nH   0.63pF
H9   A11   inbuff   67.21m   2.11nH   0.58pF
J1   CLK   clkbuff   42.43m   1.43nH   0.53pF
J2   CKE   clkbuff   62.36m   1.79nH   0.58pF
J3   A9   inbuff   43.73m   1.41nH   0.64pF
J7   BA0   inbuff   74.58m   2.39nH   0.73pF
J8   CS#   inbuff   42.92m   1.29nH   0.60pF
J9   RAS#   inbuff   40.31m   1.25nH   0.52pF
K1   DQM1   inbuff   71.78m   2.05nH   0.58pF
K2   NC   NC
K3   NC   NC
K7   CAS#   inbuff   41.11m   1.42nH   0.66pF
K8   WE#   inbuff2   63.59m   1.96nH   0.61pF
K9   DQM0   inbuff   73.75m   2.08nH   0.55pF
L1   VDDQ   POWER   36.32m   1.53nH   10.4pF
L2   DQ8   dqbuff   39.06m   1.51nH   0.71pF
L3   VSS   GND   25.14m   1.09nH   8.32pF
L7   VDD   POWER   25.09m   1.22nH   8.85pF
L8   DQ7   dqbuff   56.13m   2.21nH   0.65pF
L9   VSSQ   GND   42.42m   1.41nH   10.8pF
M1   VSSQ   GND   85.91m   3.35nH   10.8pF
M2   DQ10   dqbuff   42.82m   1.58nH   0.49pF
M3   DQ9   dqbuff   50.58m   2.12nH   0.55pF
M7   DQ6   dqbuff   76.98m   2.19nH   0.64pF
M8   DQ5   dqbuff   74.78m   2.29nH   0.59pF
M9   VDDQ   POWER   96.15m   3.58nH   10.4pF
N1   VSSQ   GND   74.52m   2.44nH   10.8pF
N2   DQ12   dqbuff   40.70m   1.84nH   0.50pF
N3   DQ14   dqbuff   87.14m   2.44nH   0.47pF
N7   DQ1   dqbuff   38.69m   1.80nH   0.48pF
N8   DQ3   dqbuff   55.29m   1.88nH   0.45pF
N9   VDDQ   POWER   51.03m   1.84nH   10.4pF
P1   DQ11   dqbuff   51.59m   1.93nH   0.53pF
P2   VDDQ   POWER   57.65m   2.75nH   10.4pF
P3   VSSQ   GND   79.80m   2.56nH   10.8pF
P7   VDDQ   POWER   25.70m   1.15nH   10.4pF
P8   VSSQ   GND   85.09m   2.68nH   10.8pF
P9   DQ4   dqbuff   71.39m   2.54nH   0.42pF
R1   DQ13   dqbuff   69.94m   2.40nH   0.53pF
R2   DQ15   dqbuff   106.0m   3.55nH   0.66pF
R3   VSS   GND   25.14m   1.09nH   8.32pF
R7   VDD   POWER   38.87m   2.02nH   8.85pF
R8   DQ0   dqbuff   53.26m   1.92nH   0.65pF
R9   DQ2   dqbuff   32.11m   1.35nH   0.55pF
|   inbuff2 MODEL
[Model]   inbuff2
Model_type   Input
| Used for WE and A12. Contains no clamp structures
Vinl = 800.000mV
Vinh = 2.000V
|   typ   min   max
C_comp   2.720pF   2.130pF   3.310pF
[Voltage Range]   3.300V   3.000V   3.600V
[Temperature Range]   25.0   85.0   0.0
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| Models and submodels in the file (4): clkbuff (Input), dqbuff (I/O), inbuff2 (Input), inbuff (Input)
