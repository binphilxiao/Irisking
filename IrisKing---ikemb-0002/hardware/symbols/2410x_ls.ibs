[IBIS ver]   2.1
[File name]   2410x_ls.ibs
[File Rev]   0.00
[Date]   Wednesday, July 3, 2002
[Source]   The Following information corresponds to the S3C2410X01.
[Notes]   This IBIS model is based on simulated data.
[Disclaimer] This IBIS model provided "as is". SAMSUNG is not
                 responsible for any problems this model may cause to
                 the customers. Customers may only modify the IBIS model
                 to fit their particular application.
[Copyright]   Copyright 2002. SAMSUNG Electronics Co.
   All rights reserved
|   Component S3C2410X01
[Component]   S3C2410X01
[Manufacturer]   SAMSUNG Electronics Co., LTD.
[Package]
| variable   typ   min   max
R_pkg   100mOhm   NA   NA
L_pkg   7nH   NA   NA
C_pkg   0.8pF   NA   NA
[Pin]  signal_name   model_name  R_pin   L_pin   C_pin
A1  DATA19   phbsu100ct12sm
A2  DATA18   phbsu100ct12sm
A3  DATA16   phbsu100ct12sm
A4  DATA15   phbsu100ct12sm
A5  DATA11   phbsu100ct12sm
A6  VDDMOP   POWER
A7  DATA6   phbsu100ct12sm
A8  DATA1   phbsu100ct12sm
A9  ADDR21   phot8
A10 ADDR161   phot8
A11 ADDR13   phot8
A12 VSSMOP   GND
A13 ADDR6   phot8
A14 ADDR2   phot8
A15 VDDMOP   POWER
A16 nBE3   phot8
A17 nBE0   phot8
B1  DATA22   phbsu100ct12sm
B2  DATA20   phbsu100ct12sm
B3  DATA17   phbsu100ct12sm
B4  VDDMOP   POWER
B5  DATA13   phbsu100ct12sm
B6  DATA9   phbsu100ct12sm
B7  DATA5   phbsu100ct12sm
B8  DATA0   phbsu100ct12sm
B9  ADDR24   phot8
B10 ADDR17   phot8
B11 ADDR12   phot8
B12 ADDR8   phot8
B13 ADDR4   phot8
B14 ADDR0   phot8
B15 nSRAS   phot8
B16 nBE1   phot8
B17 VSSi   GND
C1  DATA24   phbsu100ct12sm
C2  DATA23   phbsu100ct12sm
C3  DATA21   phbsu100ct12sm
C4  VDDi   POWER
C5  DATA12   phbsu100ct12sm
C6  DATA7   phbsu100ct12sm
C7  DATA4   phbsu100ct12sm
C8  VDDi   POWER
C9  ADDR25   phot8
C10 VSSMOP   GND
C11 ADDR14   phot8
C12 ADDR7   phot8
C13 ADDR3   phot8
C14 nSCAS   phot8
C15 nBE2   phot8
C16 nOE   phot8
C17 VDDi   POWER
D1  DATA27   phbsu100ct12sm
D2  DATA25   phbsu100ct12sm
D3  VSSMOP   GND
D4  DATA26   phbsu100ct12sm
D5  DATA14   phbsu100ct12sm
D6  DATA10   phbsu100ct12sm
D7  DATA2   phbsu100ct12sm
D8  VDDMOP   POWER
D9  ADDR22   phot8
D10 ADDR19   phot8
D11 VDDi   POWER
D12 ADDR10   phot8
D13 ADDR5   phot8
D14 ADDR1   phot8
D15 VSSMOP   GND
D16 SCKE   phot8
D17 nGCS0   phot8
E1  DATA31   phbsu100ct12sm
E2  DATA29   phbsu100ct12sm
E3  DATA28   phbsu100ct12sm
E4  DATA30   phbsu100ct12sm
E5  VDDMOP   POWER
E6  VSSMOP   GND
E7  DATA3   phbsu100ct12sm
E8  ADDR26   phot8
E9  ADDR23   phot8
E10 ADDR18   phot8
E11 VDDMOP   POWER
E12 ADDR11   phot8
E13 nWE   phot8
E14 nGCS3   phot8
E15 nGCS1   phot8
E16 nGCS2   phot8
E17 nGCS4   phot8
F1  TOUT1   phbsu100ct8sm
F2  TOUT0   phbsu100ct8sm
F3  VSSMOP   GND
F4  TOUT2   phbsu100ct8sm
F5  VSSOP   GND
F6  VSSi   GND
F7  DATA8   phbsu100ct12sm
F8  VSSMOP   GND
F9  VSSi   GND
F10 ADDR20   phot8
F11 VSSi   GND
F12 VSSMOP   GND
F13 SCLK0   phot16sm
F14 SCLK1   phot16sm
F15 nGCS5   phot8
F16 nGCS6   phot8
F17 nGCS7   phot8
G1  nXBACK   phbsu100ct8sm
G2  nXDACK1   phbsu100ct8sm
G3  TOUT3   phbsu100ct8sm
G4  TCLK0   phbsu100ct8sm
G5  nXBREQ   phbsu100ct8sm
G6  VDDalive  POWER
G7  VDDiarm   POWER
G9  VSSMOP   GND
G11 ADDR15   phot8
G12 ADDR9   phot8
G13 nWAIT   phis
G14 ALE   phob8
G15 nFWE   phob8
G16 nFRE   phob8
G17 nFCE   phob8
H1  VSSiarm   GND
H2  nXDACK0   phbsu100ct8sm
H3  nXDREQ0   phbsu100ct8sm
H4  nXDREQ1   phbsu100ct8sm
H5  nTRST   phis
H6  TCK   phis
H12 CLE   phob8
H13 VSSOP   GND
H14 VDDMOP   POWER
H15 VSSi   GND
H16 XTOpll   phsoscm26_PADY
H17 XTIpll   phsoscm26_PADA
J1  TDI   phis
J2  VCLK   phbsu100ct8sm
J3  TMS   phis
J4  LEND   phbsu100ct8sm
J5  TDO   phot8
J6  VLINE   phbsu100ct8sm
J7  VSSiarm   GND
J11 EXTCLK   phis
J12 nRESET   phis
J13 VDDi   POWER
J14 VDDalive  POWER
J15 PWREN   phob8
J16 nRSTOUT   phob8
J17 BATT_FLT  phis
K1  VDDOP   POWER
K2  VM   phbsu100ct8sm
K3  VDDiarm   POWER
K4  VFRAME   phbsu100ct8sm
K5  VSSOP   GND
K6  LCDVF0   phbsu100ct8sm
K12 RXD2   phbsu100ct8sm
K13 TXD2   phbsu100ct8sm
K14 RXD1   phbsu100ct8sm
K15 TXD0   phbsu100ct8sm
K16 TXD1   phbsu100ct8sm
K17 RXD0   phbsu100ct8sm
L1  VD0   phbsu100ct8sm
L2  VD1   phbsu100ct8sm
L3  LCDVF2   phbsu100ct8sm
L4  VD2   phbsu100ct8sm
L5  VDDiarm   POWER
L6  LCDVF1   phbsu100ct8sm
L7  IICSCL   phbsu100cd8sm
L9  EINT11   phbsu100ct8sm
L11 VDDi_UPLL POWER
L12 nRTS0   phbsu100ct8sm
L13 UPLLCAP   phgpad_option
L14 nCTS0   phbsu100ct8sm
L15 EINT6   phbsu100ct8sm
L16 UCLK   phbsu100ct8sm
L17 EINT7   phbsu100ct8sm
M1  VSSiarm   GND
M2  VD5   phbsu100ct8sm
M3  VD3   phbsu100ct8sm
M4  VD4   phbsu100ct8sm
M5  VSSiarm   GND
M6  VDDOP   POWER
M7  VDDiarm   POWER
M8  IICSDA   phbsu100cd8sm
M9  VSSiarm   GND
M10 DP1/PDP0  pbusb_DP
M11 EINT23   phbsu100ct12sm
M12 RTCVDD   POWER
M13 VSSi_MPLL GND
M14 EINT5   phbsu100ct8sm
M15 EINT4   phbsu100ct8sm
M16 EINT2   phbsu100ct8sm
M17 EINT3   phbsu100ct8sm
N1  VD6   phbsu100ct8sm
N2  VD8   phbsu100ct8sm
N3  VD7   phbsu100ct8sm
N4  VD9   phbsu100ct8sm
N5  VDDiarm   POWER
N6  CDCLK   phbsu100ct8sm
N7  SDDAT1   phbsu100ct8sm
N8  VSSiarm   GND
N9  VDDOP   POWER
N10 VDDiarm   POWER
N11 DN1   pbusb_DN
N12 Vref   phia_abb
N13 AIN7   phiar10_abb
N14 EINT0   phbsu100ct8sm
N15 VSSi_UPLL GND
N16 VDDOP   POWER
N17 EINT1   phbsu100ct8sm
P1  VD10   phbsu100ct8sm
P2  VD12   phbsu100ct8sm
P3  VD11   phbsu100ct8sm
P4  VD23   phbsu100ct8sm
P5  I2SSCLK   phbsu100ct8sm
P6  SDCMD   phbsu100ct8sm
P7  SDDAT2   phbsu100ct8sm
P8  SPICLK0   phbsu100ct8sm
P9  EINT12   phbsu100ct8sm
P10 EINT18   phtbsu100ct6sm
P11 EINT20   phbsu100ct12sm
P12 VSSOP   GND
P13 DP0   pbusb_DP
P14 VDDi_MPLL POWER
P15 VDDA_ADC  POWER
P16 XTIrtc   phgpad_option
P17 MPLLCAP   phgpad_option
R1  VDDiarm   POWER
R2  VD14   phbsu100ct8sm
R3  VD17   phbsu100ct8sm
R4  VD18   phbsu100ct8sm
R5  VSSOP   GND
R6  SDDAT0   phbsu100ct8sm
R7  SDDAT3   phbsu100ct8sm
R8  EINT8   phbsu100ct8sm
R9  EINT14   phbsu100ct8sm
R10 EINT15   phbsu100ct8sm
R11 EINT19   phbsu100ct12sm
R12 CLKOUT0   phbsu100ct12sm
R13 NCON0   phis
R14 OM0   phis
R15 AIN4   phiar10_abb
R16 AIN6   phiar10_abb
R17 XTOrtc   phgpad_option
T1  VD13   phbsu100ct8sm
T2  VD16   phbsu100ct8sm
T3  VD20   phbsu100ct8sm
T4  VD22   phbsu100ct8sm
T5  I2SLRCK   phbsu100ct8sm
T6  SDCLK   phbsu100ct8sm
T7  SPIMISO0  phbsu100ct8sm
T8  EINT10   phbsu100ct8sm
T9  VSSOP   GND
T10 EINT17   phtbsu100ct6sm
T11 EINT22   phbsu100ct12sm
T12 DN0   pbusb_DN
T13 OM3   phis
T14 VSSA_ADC  GND
T15 AIN1   phiar10_abb
T16 AIN3   phiar10_abb
T17 AIN5   phiar10_abb
U1  VD15   phbsu100ct8sm
U2  VD19   phbsu100ct8sm
U3  VD21   phbsu100ct8sm
U4  VSSiarm   GND
U5  I2SSDI   phbsu100ct8sm
U6  I2SSDO   phbsu100ct8sm
U7  SPIMOSI0  phbsu100ct8sm
U8  EINT9   phbsu100ct8sm
U9  EINT13   phbsu100ct8sm
U10 EINT16   phtbsu100ct6sm
U11 EINT21   phbsu100ct12sm
U12 CLKOUT1   phbsu100ct12sm
U13 NCON1   phis
U14 OM2   phis
U15 OM1   phis
U16 AIN0   phiar10_abb
U17 AIN2   phiar10_abb
[Model] phgpad_option
 Model_type  Input
 Polarity   Non-Inverting
 Vinh= 2.00
 Vinl= 0.80
|variable   typ   min   max
 C_comp   2pF   2pF   2pF
|variable   typ   min   max
[Temperature Range]   25.0   0   70
|variable   typ   min   max
[Voltage Range]   3.3V   3.0V   3.6V
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[Model] phia_abb
 Model_type  Input
 Polarity   Non-Inverting
 Vinh= 2.00
 Vinl= 0.80
|variable   typ   min   max
 C_comp   2pF   2pF   2pF
|variable   typ   min   max
[Temperature Range]   25.0   0   70
|variable   typ   min   max
[Voltage Range]   3.3V   3.0V   3.6V
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[Model] phiar10_abb
 Model_type  Input
 Polarity   Non-Inverting
 Vinh= 2.00
 Vinl= 0.80
|variable   typ   min   max
 C_comp   2pF   2pF   2pF
|variable   typ   min   max
[Temperature Range]   25.0   0   70
|variable   typ   min   max
[Voltage Range]   3.3V   3.0V   3.6V
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| Models and submodels in the file (15): phis (Input), phot8 (3-state), phob8 (Output), phot16sm (3-state), phsoscm26_PADY (Output), phsoscm26_PADA (Input), phtbsu100ct6sm (I/O), phbsu100ct8sm (I/O), phbsu100ct12sm (I/O), phbsu100cd8sm (I/O_open_drain), pbusb_DP (3-state), pbusb_DN (3-state), phgpad_option (Input), phia_abb (Input), phiar10_abb (Input)
